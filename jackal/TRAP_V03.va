/*
 *   Composite trap model for the Jackal FET
 *   Version 0.3
 *
 *	   This version is a re-do of version 0.2 in which the topology
 *	   is changed due to an issue with the trap recovery to an
 *	   RF pulse
 */

`include "disciplines.h"
`include "constants.h"

`define   GMIN      1.0e-12
`define   CTOK      273.15
`define   MAX_EXP   60.0

/////////////////////////////////////////////////////////////////////////
/////////////////////////////////////////////////////////////////////////

module TRAP_V03 ( vc1, vc2, Tj, itrap );
    inout         vc1, vc2, Tj, itrap ;
    electrical    vc1, vc2,     itrap, n1, n2, n3;
    thermal                 Tj         ;

    (* desc = "direct magnitude", units = "" *)
    parameter real A = 0.03 from (-inf:inf);

    (* desc = "emission time", units = "" *)
    parameter real ET = 2.0e-6 from [1.0e-15:inf);

    (* desc = "capture time", units = "" *)
    parameter real CT = 1.0e-7 from [1.0e-15:inf);

    (* desc = "trap filter network capacitor size", units = "" *)
    parameter real CAP = 1e-9 from [1e-18:inf);

    (* desc = "transistion region smoothing paramter", units = "" *)
    parameter real ALPHA = 0.0 from [0:inf);

    (* desc = "erf term magnitude", units = "" *)
    parameter real E = 0.0 from (-inf:inf);

    (* desc = "erf term argument multipying factor", units = "" *)
    parameter real E_FACT = 0.1 from (-inf:inf);

    (* desc = "erf term argument offset factor", units = "" *)
    parameter real E_OFFS = 0.0 from (-inf:inf);

    (* desc = "activation energy for emission", units = "" *)
    parameter real EA_EMI = 0.5 from [0:inf);

    (* desc = "activation energy for capture", units = "" *)
    parameter real EA_CAP = 0.5 from [0:inf);

    (* desc = "linear temperature coefficient for trap magnitude", units = "" *)
    parameter real T_FACT = 0.0 from (-inf:inf);

    (* desc = "minimum temperature in Kelvin for the linear temperature coefficient", units = "" *)
    parameter real T_MIN_K = 10.0 from [0:inf);

    (* desc = "maximum temperature in Kelvin for the linear temperature coefficient", units = "" *)
    parameter real T_MAX_K = 500.0 from [0:inf);

    (* desc = "linear temperature coefficient smoothing factor", units = "" *)
    parameter real T_ALPHA = 0.0 from [0:inf);

	analog function real exp1;
		// a limiting exponential that is continuous through the
		// second derivative
		input x;
		real x;
		begin
			if (x > `MAX_EXP)
				exp1 = exp(`MAX_EXP)*(1.0 + (x-`MAX_EXP) + 0.5*(x-`MAX_EXP)*(x-`MAX_EXP));
			else
				exp1 = exp(x);
		end
	endfunction

    analog function real lower_delta_limit;
        // compute the lower delta limit between 2 values v1 and v2
		// this function will return the value of v1-v2, but with a smoothing
		// limit to 0 when v2>v1, the radius of the smoothing is set by
		// the alpha parameter
		// the return value of this function will always be >=0
        input v1, v2, alpha;
        real  v1, v2, alpha;
        begin
            lower_delta_limit = 0.5*((v1-v2) + sqrt((v1-v2)*(v1-v2)+alpha));
        end
    endfunction //lower_delta_limit

    analog function real range_limit;
        // limit the range of parameter v to within the range
		// set by the lower and upper parameters, alpha creates
		// a smoothing radius in the regions around the lower and
		// upper boundaries
        input v, lower, upper, alpha;
        real  v, lower, upper, alpha;
		real t;
        begin
			// lower side
            t = 0.5*(lower + v + sqrt((v-lower)*(v-lower)+alpha));
			// upper side
			range_limit = 0.5*(upper + t - sqrt((t-upper)*(t-upper)+alpha));
        end
    endfunction //range_limit

`include "erf.h"

    /*****************************************************************************/
    /*****************************************************************************/

    analog begin : main
        real invk, t0;
        real tkelvin, tfact;
		real tf_emission, tf_capture, g_capture, g_emission;
        real m, vcontrol;

        /////////////////////////////////////////////////////////////////////////
        @(initial_step) begin : atstart
            // compute constants
            invk = 1.0 / 8.617332478e-5;
			t0 = `CTOK;
        end
        /////////////////////////////////////////////////////////////////////////

		// compute the temp in Kelvin and the activation energy temperature factor
        tkelvin = range_limit(Temp(Tj)+t0,0.1,2000.0,0.1);
		tfact = 1.0/tkelvin - 1.0/t0;

		// activivation energy modification of trap time constants
        tf_emission = exp1(EA_EMI*tfact*invk);
		tf_capture = exp1(EA_CAP*tfact*invk);

		// trap emission and capture conductances
		g_capture = CAP/(CT*tf_capture);
		g_emission = CAP/(ET*tf_emission);

		// control terminal differential voltage
		vcontrol = V(vc1,vc2);

		// trap magnitude calculation, this is the combination of 3 terms
		// - a constant multiplier (A)
		// - a erf() control voltage multiplier (using E, E_FACT, and E_OFFS)
		// - a linear temperature multiplier (using T_FACT, T_MIN_K, T_MAX_K, and T_ALPHA)
		m = A + E*0.5*(1.0+erf(E_FACT*(vcontrol-E_OFFS))) + T_FACT*(T_MAX_K - range_limit(tkelvin,T_MIN_K,T_MAX_K,T_ALPHA));

		// trap emission and capture filter components implemented in a stretched-exponential manner
		I(n1)    <+  CAP*ddt(V(n1)-vcontrol) + lower_delta_limit(V(n1),0.0,ALPHA)*g_emission - lower_delta_limit(-V(n1),0.0,ALPHA)*g_capture;
		I(n2)    <+  CAP*ddt(V(n2)-vcontrol) + 0.4*lower_delta_limit(V(n2),0.0,ALPHA)*g_emission - lower_delta_limit(-V(n2),0.0,ALPHA)*g_capture;
		I(n3)    <+  CAP*ddt(V(n3)-vcontrol) + 0.16*lower_delta_limit(V(n3),0.0,ALPHA)*g_emission - lower_delta_limit(-V(n3),0.0,ALPHA)*g_capture;

		// total trap output voltage (returned as a current to make summation easier)
        I(itrap)  <+ m*(0.625*V(n1) + 0.25*V(n2) + 0.125*V(n3));

    end

endmodule
