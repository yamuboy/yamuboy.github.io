/*
      Gate lag model for the Jackal FET
      Version 0.1
*/

`include "disciplines.h"
`include "constants.h"

`define   GMIN      1.0e-12
`define   CTOK      273.15

/////////////////////////////////////////////////////////////////////////
/////////////////////////////////////////////////////////////////////////

module DLAG_V02 ( vd, vs, Tj, itrap );
    inout         vd, vs, Tj, itrap ;
    electrical    vd, vs,     itrap, n1 ;
    thermal               Tj         ;

    (* desc = "drain lag magnitude at Vds=0", units = "" *)
    parameter real A = -0.005 from (-inf:inf);

    (* desc = "drain lag offset", units = "" *)
    parameter real OFFS = -0.0075 from (-inf:inf);

    (* desc = "drain lag trap parameter", units = "" *)
    parameter real P1 = 0.05 from (-inf:inf);

    (* desc = "capture time", units = "" *)
    parameter real CT = 1.0e-7 from [0:inf);

    (* desc = "emission time", units = "" *)
    parameter real ET = 425e-3 from [0:inf);

    (* desc = "trap resistor", units = "" *)
    parameter real RTRAP = 1.0e-3 from [0.0001:inf);

	(* desc = "G2 offset", units = "" *)
	parameter real G2OFFS = -0.01 from (-inf:inf);

	(* desc = "G3 coefficient", units = "" *)
	parameter real G3F = 50 from (-inf:inf);

	(* desc = "G3 exponential factor", units = "" *)
	parameter real G3EXP = 0.1 from (0:inf);

    (* desc = "smoothing parameter", units = "" *)
    parameter real ALPHA = 1.0e-3 from [0:inf);

    (* desc = "activation energy for RC1", units = "" *)
    parameter real T_EA1 = 0.65 from [0:inf);

    (* desc = "activation energy for RC2", units = "" *)
    parameter real T_EA2 = 0.125 from [0:inf);

`include "erf.h"

    /*****************************************************************************/
    /*****************************************************************************/

    analog begin : main
        real cap, r1, r2, invk, alpha2, n1_scale;
        real tjunc, tkelvin, tfact1, tfact2;
        real ltm1, ltm2, r1c, r2c, r3c, g_scaled;
        real v_res, v_res1;

        /////////////////////////////////////////////////////////////////////////
        @(initial_step) begin : atstart
            // compute constants
            r1 = RTRAP;
            r2 = r1*ET/CT;
            cap = CT / r1;
            invk = 1.0 / 8.617332478e-5;
            alpha2 = pow(ALPHA,2);
            // compute a scale factor that scales the current at node 'n1' down to
            // a more reasonable value at RF frequncies by computing a factor
            // that makes the cap in the RC filter appear to be a 100 pF
            // this arbitrary scaling can be done because the voltage at 'n1'
            // is a direct function of the ratio between the 2 terms that make
            // up the current at 'n1' and therefore applying an arbitrary scale
            // factor to both terms does not affect the model
            // doing this scaling SIGNIFICANTLY improves convergence at low power
            // levels and probably at other conditions as well
            n1_scale = 1.0e-10 / cap;
        end
        /////////////////////////////////////////////////////////////////////////

        tjunc = Temp(Tj);
        tkelvin = tjunc+`CTOK;
        tfact1 = pow((`CTOK / tkelvin),2);
        tfact2 = (1.0/tkelvin - 1.0/`CTOK);

        ltm1 = tfact1*limexp(T_EA1*tfact2*invk);
        ltm2 = tfact1*limexp(T_EA2*tfact2*invk);
        r1c = r1;
        r2c = r2*ltm1;
        r3c = r2*ltm2;
        v_res = V(n1);
        v_res1 = v_res + G2OFFS;
        g_scaled = 1.0/r2c + G3F*limexp(v_res*G3EXP)/r3c + 0.5*(v_res1 + sqrt(pow(v_res1,2)+alpha2))/r1c;

        I(n1)     <+ n1_scale*(V(n1)*g_scaled + cap*ddt(V(n1)-V(vd,vs)));
        I(itrap)  <+ V(n1)*(A*(1.0 - erf(P1*V(vd,vs))) + OFFS);
        I(vd,vs)  <+ `GMIN*V(vd,vs);
        Pwr(Tj)   <+ `GMIN*Temp(Tj);

    end

endmodule
