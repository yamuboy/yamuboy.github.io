/*
      Gate lag model for the Jackal FET
      Version 0.1
*/

`include "disciplines.h"
`include "constants.h"

`define   GMIN      1.0e-12
`define   CTOK      273.15

/////////////////////////////////////////////////////////////////////////
/////////////////////////////////////////////////////////////////////////

module GLAG_V02 ( vg, vs, Tj, itrap );
    inout         vg, vs, Tj, itrap ;
    electrical    vg, vs,     itrap, n1 ;
    thermal               Tj         ;

    (* desc = "gate lag magnitude at 0C", units = "" *)
    parameter real A = 0.03 from (-inf:inf);

    (* desc = "emission time", units = "" *)
    parameter real ET = 190e-3 from (0:inf);

    (* desc = "trap resistor", units = "" *)
    parameter real RTRAP = 1000.0 from [0.0001:inf);

	(* desc = "G2 coefficient", units = "" *)
	parameter real G2F = 50 from (-inf:inf);

	(* desc = "G2 exponential factor", units = "" *)
	parameter real G2EXP = 1.0/3.0 from (0:inf);

    (* desc = "temperatute coefficient for M", units = "" *)
    parameter real T_A = 9.54e-3 from (0:inf);

    (* desc = "activation energy for RC1", units = "" *)
    parameter real T_EA1 = 0.55 from (0:inf);

    (* desc = "activation energy for RC2", units = "" *)
    parameter real T_EA2 = 0.125 from (0:inf);

`include "erf.h"

    /*****************************************************************************/
    /*****************************************************************************/

    analog begin : main
        real cap, invk, n1_scale;
        real tjunc, tkelvin, tfact1, tfact2;
        real ltm1, ltm2, rc1, rc2, g_scaled;

        /////////////////////////////////////////////////////////////////////////
        @(initial_step) begin : atstart
            // compute constants
            cap = ET / RTRAP;
            invk = 1.0 / 8.617332478e-5;
            // compute a scale factor that scales the current at node 'n1' down to
            // a more reasonable value at RF frequncies by computing a factor
            // that makes the cap in the RC filter appear to be a 100 pF
            // this arbitrary scaling can be done because the voltage at 'n1'
            // is a direct function of the ratio between the 2 terms that make
            // up the current at 'n1' and therefore applying an arbitrary scale
            // factor to both terms does not affect the model
            // doing this scaling SIGNIFICANTLY improves convergence at low power
            // levels and probably at other conditions as well
            n1_scale = 1.0e-10 / cap;
        end
        /////////////////////////////////////////////////////////////////////////

        tjunc = Temp(Tj);
        tkelvin = tjunc+`CTOK;
        tfact1 = pow((`CTOK / tkelvin),2);
        tfact2 = (1.0/tkelvin - 1.0/`CTOK);

        ltm1 = tfact1*limexp(T_EA1*tfact2*invk);
        ltm2 = tfact1*limexp(T_EA2*tfact2*invk);
        rc1 = RTRAP*ltm1;
        rc2 = RTRAP*ltm2;
        g_scaled = 1.0/rc1 + G2F*limexp(-V(n1)*G2EXP)/rc2;

        I(n1)     <+ n1_scale*(V(n1)*g_scaled + cap*ddt(V(n1)-V(vg,vs)));
        I(itrap)  <+ V(n1)*A*(1.0 - erf(T_A*tjunc));
        I(vg,vs)  <+ `GMIN*V(vg,vs);
        Pwr(Tj)   <+ `GMIN*Temp(Tj);

    end

endmodule
