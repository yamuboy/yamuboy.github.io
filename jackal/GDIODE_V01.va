/*
      Gate diode model for the Jackal FET
      Version 0.1
*/

`include "disciplines.h"
`include "constants.h"

`define   GMIN      1.0e-12
`define   SQRTPI    1.7724538509055160273

/////////////////////////////////////////////////////////////////////////
/////////////////////////////////////////////////////////////////////////

module GDIODE_V01 ( va, vc, Td );
    inout           va, vc, Td  ;
    electrical      va, vc      ;
    thermal                 Td  ;

    (* desc = "scaling factor", units = "" *)
    parameter real SF = 1.0 from (0:inf);

    (* desc = "diode saturation current factor", units = "" *)
    parameter real IS_FACT = -15.28191 from (-inf:inf);

    (* desc = "diode leakage conductance factor", units = "" *)
    parameter real GD_FACT = -6.657142 from (-inf:inf);

    (* desc = "diode exponential factor", units = "" *)
    parameter real EXP_FACT = 27.175 from (-inf:inf);

    (* desc = "Nominal (extraction) temperature for temperature scale factors", units = "" *)
    parameter real TNOM = 25.0 from [-273.15:1000.0];

    (* desc = "temperature factor for GM0", units = "" *)
    parameter real T_GM0 = -0.00187 from (-inf:inf);

    (* desc = "temperature factor for the diode saturation current", units = "" *)
    parameter real T_IS = 0.0326 from (-inf:inf);

    (* desc = "temperature factor for the diode leakage conductance", units = "" *)
    parameter real T_GD = 5.7142857e-3 from (-inf:inf);

    (* desc = "temperature factor for the diode exponetial", units = "" *)
    parameter real T_EXP = -0.041 from (-inf:inf);

    /*****************************************************************************/
    /*****************************************************************************/

    analog begin : main

        real tfact, gm0_tfact, arg;
        real Vdiode, Is, Gd_1, Vdmax, Vdlim;

        Vdiode = V(va,vc);
        tfact = Temp(Td) - TNOM;
        gm0_tfact = 1.0 + T_GM0*tfact;

        Is = 0.5*pow(10.0,(T_IS*tfact+IS_FACT))*SF;
        Gd_1 = pow(10,(T_GD*tfact+GD_FACT))*SF + `GMIN;
        arg = T_EXP*tfact + EXP_FACT;
        Vdmax = ln(1.0 + abs(0.5*gm0_tfact*SF/Is)) / arg;
        Vdlim = Vdiode - 0.5*(Vdiode-Vdmax+sqrt(pow((Vdiode-Vdmax),2) + 0.1));

        I(va,vc)  <+ Is*(exp(arg*Vdlim) - 1.0) + Gd_1*Vdiode;
        Pwr(Td)   <+ `GMIN*Temp(Td);

    end

endmodule
