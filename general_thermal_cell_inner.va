`include "constants.vams"
`include "disciplines.vams"

`define TK_ALPHA   500.0
`define TK_MIN     0.15
`define TRADIUS_SQ  1.0

module general_thermal_cell_inner(T1, T2);
    inout T1, T2;
    thermal T1, T2;

    real T, Tk, Kth, Rth, Rth_const, Q, Q_T0, Q_const;

    (* desc = "X-dimension of cell", units="m" *)
    parameter real X = 100e-6 from (0:inf);

    (* desc = "Y-dimension of cell", units="m" *)
    parameter real Y = 100e-6 from (0:inf);

    (* desc = "Z-dimension of cell", units="m" *)
    parameter real Z = 100e-6 from (0:inf);

    (* desc = "Spreading factor", units="" *)
    parameter real SF = 1.0 from [1:`M_PI];

    (* desc = "Number of fingers", units="" *)
    parameter integer NGF = 1 from [1:inf);

    (* desc = "Thermal conductivity reference temperature", units="K" *)
    parameter real K_T0 = `P_CELSIUS0 from [`TK_MIN:inf);

    (* desc = "Thermal conductivity @ T0", units="W/(m-K)" *)
    parameter real K0 = 100.0 from (0:inf);

    (* desc = "Thermal conductivity exponential factor", units="" *)
    parameter real K_ALPHA = 0.0 from (-inf:inf);

    (* desc = "Material density", units="kg/(m^3)" *)
    parameter real RHO = 1.0 from (0:inf);

    (* desc = "Specific heat capacity constant", units="J/(kg-K)" *)
    parameter real C0 = 1.0 from (-inf:inf);

    (* desc = "Specific heat capacity arctan coefficient", units="J/(kg-K)" *)
    parameter real C1 = 0.0 from (-inf:inf);

    (* desc = "Specific heat capacity arctan argument coefficient", units="1/K" *)
    parameter real C2 = 1.0 from (-inf:inf);

    (* desc = "Specific heat capacity arctan argument offset", units="K" *)
    parameter real C3 = 0.0 from (-inf:inf);

    //need to pass in module parameters as arguments because AWR Model Wizard will not translate usage of module parameters
    //inside of a function
    analog function real Cp_integral;
        input T, C0, C1, C2, C3;
        real T, C0, C1, C2, C3;

        begin
            //antiderivative of C0 + C1*atan(C2*(T - C3)) with respect to T
            Cp_integral = C0*T - (C1*ln(C2*C2*(C3 - T)*(C3 - T) + 1))/(2*C2) + C1*T*atan(C2*(T - C3)) + C1*C3*atan(C2*(C3 - T));
        end
    endfunction

    analog begin

        @(initial_step) begin
            //calculate static Rth component
            //if X != Y
            if(abs(X - Y) > 1e-12) begin
                Rth_const = (ln(X*(Y+2.0*SF*Z))-ln((Y*(X+2.0*SF*Z))))/(2.0*SF*(X - Y)*NGF);
            end
            //if X == Y, take limit of above equation as x -> y
            else begin
                Rth_const = Z/((NGF*Y)*(Y+2.0*SF*Z));
            end
            Q_T0 = Cp_integral(`P_CELSIUS0, C0, C1, C2, C3);
            Q_const = NGF*(Y + SF*Z)*(X + SF*Z)*Z*RHO;
        end

        //get temperature for this cell and limit it to defined minimum temperature
        Tk = Temp(T1) + `P_CELSIUS0;
        T = 0.5*(Tk-`TK_MIN+sqrt((Tk-`TK_MIN)*(Tk-`TK_MIN)+`TK_ALPHA))+`TK_MIN;

        //calculate thermal conductivity of this cell based on current temperature
        Kth = K0*pow((T/K_T0),K_ALPHA);

        //calculate thermal resistance of this cell
        Rth = Rth_const/Kth;

        //calculate volumetric heat capacity of this cell based on current temperature
        Q = Q_const*(Cp_integral(T, C0, C1, C2, C3) - Q_T0);

        Pwr(T1, T2) <+ Temp(T1, T2)/Rth;
        Pwr(T1)     <+ ddt(Q);
    end

endmodule
